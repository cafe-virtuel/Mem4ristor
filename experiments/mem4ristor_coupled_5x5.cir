* Mem4ristor v3 - 5x5 Coupled Network
* Network: 5x5 = 25 units with 4-neighbor periodic coupling

.title Mem4ristor v3 Coupled Network (5x5)

* ── Global Parameters ──
.param a=0.7
.param b=0.8
.param eps=0.08
.param alpha_cog=0.15
.param eps_u=0.02
.param sigma_base=0.05
.param D_eff=0.030000
.param dt=0.05

* ── Unit Time Constant (RC = 1) ──
.param R_int=1
.param C_int=1

* ── State Variables (RC Integrators) ──
* Unit 0
R_v0 v0_node v0_int {R_int}
C_v0 v0_int 0 {C_int} IC=-0.23
R_w0 w0_node w0_int {R_int}
C_w0 w0_int 0 {C_int} IC=0.0
R_u0 u0_node u0_int {R_int}
C_u0 u0_int 0 {C_int} IC=0.05

* Unit 1
R_v1 v1_node v1_int {R_int}
C_v1 v1_int 0 {C_int} IC=0.75
R_w1 w1_node w1_int {R_int}
C_w1 w1_int 0 {C_int} IC=0.0
R_u1 u1_node u1_int {R_int}
C_u1 u1_int 0 {C_int} IC=0.05

* Unit 2
R_v2 v2_node v2_int {R_int}
C_v2 v2_int 0 {C_int} IC=0.43
R_w2 w2_node w2_int {R_int}
C_w2 w2_int 0 {C_int} IC=0.0
R_u2 u2_node u2_int {R_int}
C_u2 u2_int 0 {C_int} IC=0.05

* Unit 3
R_v3 v3_node v3_int {R_int}
C_v3 v3_int 0 {C_int} IC=-0.01
R_w3 w3_node w3_int {R_int}
C_w3 w3_int 0 {C_int} IC=0.0
R_u3 u3_node u3_int {R_int}
C_u3 u3_int 0 {C_int} IC=0.05

* Unit 4
R_v4 v4_node v4_int {R_int}
C_v4 v4_int 0 {C_int} IC=-0.08
R_w4 w4_node w4_int {R_int}
C_w4 w4_int 0 {C_int} IC=0.0
R_u4 u4_node u4_int {R_int}
C_u4 u4_int 0 {C_int} IC=0.05

* Unit 5
R_v5 v5_node v5_int {R_int}
C_v5 v5_int 0 {C_int} IC=-0.77
R_w5 w5_node w5_int {R_int}
C_w5 w5_int 0 {C_int} IC=0.0
R_u5 u5_node u5_int {R_int}
C_u5 u5_int 0 {C_int} IC=0.05

* Unit 6
R_v6 v6_node v6_int {R_int}
C_v6 v6_int 0 {C_int} IC=0.56
R_w6 w6_node w6_int {R_int}
C_w6 w6_int 0 {C_int} IC=0.0
R_u6 u6_node u6_int {R_int}
C_u6 u6_int 0 {C_int} IC=0.05

* Unit 7
R_v7 v7_node v7_int {R_int}
C_v7 v7_int 0 {C_int} IC=0.03
R_w7 w7_node w7_int {R_int}
C_w7 w7_int 0 {C_int} IC=0.0
R_u7 u7_node u7_int {R_int}
C_u7 u7_int 0 {C_int} IC=0.05

* Unit 8
R_v8 v8_node v8_int {R_int}
C_v8 v8_int 0 {C_int} IC=0.25
R_w8 w8_node w8_int {R_int}
C_w8 w8_int 0 {C_int} IC=0.0
R_u8 u8_node u8_int {R_int}
C_u8 u8_int 0 {C_int} IC=0.05

* Unit 9
R_v9 v9_node v9_int {R_int}
C_v9 v9_int 0 {C_int} IC=0.99
R_w9 w9_node w9_int {R_int}
C_w9 w9_int 0 {C_int} IC=0.0
R_u9 u9_node u9_int {R_int}
C_u9 u9_int 0 {C_int} IC=0.05

* Unit 10
R_v10 v10_node v10_int {R_int}
C_v10 v10_int 0 {C_int} IC=0.63
R_w10 w10_node w10_int {R_int}
C_w10 w10_int 0 {C_int} IC=0.0
R_u10 u10_node u10_int {R_int}
C_u10 u10_int 0 {C_int} IC=0.05

* Unit 11
R_v11 v11_node v11_int {R_int}
C_v11 v11_int 0 {C_int} IC=-0.91
R_w11 w11_node w11_int {R_int}
C_w11 w11_int 0 {C_int} IC=0.0
R_u11 u11_node u11_int {R_int}
C_u11 u11_int 0 {C_int} IC=0.05

* Unit 12
R_v12 v12_node v12_int {R_int}
C_v12 v12_int 0 {C_int} IC=0.83
R_w12 w12_node w12_int {R_int}
C_w12 w12_int 0 {C_int} IC=0.0
R_u12 u12_node u12_int {R_int}
C_u12 u12_int 0 {C_int} IC=0.05

* Unit 13
R_v13 v13_node v13_int {R_int}
C_v13 v13_int 0 {C_int} IC=-0.66
R_w13 w13_node w13_int {R_int}
C_w13 w13_int 0 {C_int} IC=0.0
R_u13 u13_node u13_int {R_int}
C_u13 u13_int 0 {C_int} IC=0.05

* Unit 14
R_v14 v14_node v14_int {R_int}
C_v14 v14_int 0 {C_int} IC=-0.68
R_w14 w14_node w14_int {R_int}
C_w14 w14_int 0 {C_int} IC=0.0
R_u14 u14_node u14_int {R_int}
C_u14 u14_int 0 {C_int} IC=0.05

* Unit 15
R_v15 v15_node v15_int {R_int}
C_v15 v15_int 0 {C_int} IC=-0.63
R_w15 w15_node w15_int {R_int}
C_w15 w15_int 0 {C_int} IC=0.0
R_u15 u15_node u15_int {R_int}
C_u15 u15_int 0 {C_int} IC=0.05

* Unit 16
R_v16 v16_node v16_int {R_int}
C_v16 v16_int 0 {C_int} IC=-0.08
R_w16 w16_node w16_int {R_int}
C_w16 w16_int 0 {C_int} IC=0.0
R_u16 u16_node u16_int {R_int}
C_u16 u16_int 0 {C_int} IC=0.05

* Unit 17
R_v17 v17_node v17_int {R_int}
C_v17 v17_int 0 {C_int} IC=0.61
R_w17 w17_node w17_int {R_int}
C_w17 w17_int 0 {C_int} IC=0.0
R_u17 u17_node u17_int {R_int}
C_u17 u17_int 0 {C_int} IC=0.05

* Unit 18
R_v18 v18_node v18_int {R_int}
C_v18 v18_int 0 {C_int} IC=-0.19
R_w18 w18_node w18_int {R_int}
C_w18 w18_int 0 {C_int} IC=0.0
R_u18 u18_node u18_int {R_int}
C_u18 u18_int 0 {C_int} IC=0.05

* Unit 19
R_v19 v19_node v19_int {R_int}
C_v19 v19_int 0 {C_int} IC=-0.74
R_w19 w19_node w19_int {R_int}
C_w19 w19_int 0 {C_int} IC=0.0
R_u19 u19_node u19_int {R_int}
C_u19 u19_int 0 {C_int} IC=0.05

* Unit 20
R_v20 v20_node v20_int {R_int}
C_v20 v20_int 0 {C_int} IC=0.30
R_w20 w20_node w20_int {R_int}
C_w20 w20_int 0 {C_int} IC=0.0
R_u20 u20_node u20_int {R_int}
C_u20 u20_int 0 {C_int} IC=0.05

* Unit 21
R_v21 v21_node v21_int {R_int}
C_v21 v21_int 0 {C_int} IC=0.08
R_w21 w21_node w21_int {R_int}
C_w21 w21_int 0 {C_int} IC=0.0
R_u21 u21_node u21_int {R_int}
C_u21 u21_int 0 {C_int} IC=0.05

* Unit 22
R_v22 v22_node v22_int {R_int}
C_v22 v22_int 0 {C_int} IC=-0.77
R_w22 w22_node w22_int {R_int}
C_w22 w22_int 0 {C_int} IC=0.0
R_u22 u22_node u22_int {R_int}
C_u22 u22_int 0 {C_int} IC=0.05

* Unit 23
R_v23 v23_node v23_int {R_int}
C_v23 v23_int 0 {C_int} IC=-0.82
R_w23 w23_node w23_int {R_int}
C_w23 w23_int 0 {C_int} IC=0.0
R_u23 u23_node u23_int {R_int}
C_u23 u23_int 0 {C_int} IC=0.05

* Unit 24
R_v24 v24_node v24_int {R_int}
C_v24 v24_int 0 {C_int} IC=-0.97
R_w24 w24_node w24_int {R_int}
C_w24 w24_int 0 {C_int} IC=0.0
R_u24 u24_node u24_int {R_int}
C_u24 u24_int 0 {C_int} IC=0.05

* ── Unit Dynamics ──
* Unit 0: dv/dt
B_dv0 v0_node 0 V = V(v0_int) - pow(V(v0_int),3)/5 - V(w0_int) + D_eff * (tanh(3.14159*(0.5 - V(u0_int))) + 0.05) * ((V(v20_int) - V(v0_int)) + (V(v5_int) - V(v0_int)) + (V(v4_int) - V(v0_int)) + (V(v1_int) - V(v0_int))) - alpha_cog*tanh(V(v0_int))
B_dw0 w0_node 0 V = eps * (V(v0_int) + a - b * V(w0_int))
B_du0 u0_node 0 V = eps_u * (sigma_base - V(u0_int))

* Unit 1: dv/dt
B_dv1 v1_node 0 V = V(v1_int) - pow(V(v1_int),3)/5 - V(w1_int) + D_eff * (tanh(3.14159*(0.5 - V(u1_int))) + 0.05) * ((V(v21_int) - V(v1_int)) + (V(v6_int) - V(v1_int)) + (V(v0_int) - V(v1_int)) + (V(v2_int) - V(v1_int))) - alpha_cog*tanh(V(v1_int))
B_dw1 w1_node 0 V = eps * (V(v1_int) + a - b * V(w1_int))
B_du1 u1_node 0 V = eps_u * (sigma_base - V(u1_int))

* Unit 2: dv/dt
B_dv2 v2_node 0 V = V(v2_int) - pow(V(v2_int),3)/5 - V(w2_int) + D_eff * (tanh(3.14159*(0.5 - V(u2_int))) + 0.05) * ((V(v22_int) - V(v2_int)) + (V(v7_int) - V(v2_int)) + (V(v1_int) - V(v2_int)) + (V(v3_int) - V(v2_int))) - alpha_cog*tanh(V(v2_int))
B_dw2 w2_node 0 V = eps * (V(v2_int) + a - b * V(w2_int))
B_du2 u2_node 0 V = eps_u * (sigma_base - V(u2_int))

* Unit 3: dv/dt
B_dv3 v3_node 0 V = V(v3_int) - pow(V(v3_int),3)/5 - V(w3_int) + D_eff * (tanh(3.14159*(0.5 - V(u3_int))) + 0.05) * ((V(v23_int) - V(v3_int)) + (V(v8_int) - V(v3_int)) + (V(v2_int) - V(v3_int)) + (V(v4_int) - V(v3_int))) - alpha_cog*tanh(V(v3_int))
B_dw3 w3_node 0 V = eps * (V(v3_int) + a - b * V(w3_int))
B_du3 u3_node 0 V = eps_u * (sigma_base - V(u3_int))

* Unit 4: dv/dt
B_dv4 v4_node 0 V = V(v4_int) - pow(V(v4_int),3)/5 - V(w4_int) + D_eff * (tanh(3.14159*(0.5 - V(u4_int))) + 0.05) * ((V(v24_int) - V(v4_int)) + (V(v9_int) - V(v4_int)) + (V(v3_int) - V(v4_int)) + (V(v0_int) - V(v4_int))) - alpha_cog*tanh(V(v4_int))
B_dw4 w4_node 0 V = eps * (V(v4_int) + a - b * V(w4_int))
B_du4 u4_node 0 V = eps_u * (sigma_base - V(u4_int))

* Unit 5: dv/dt
B_dv5 v5_node 0 V = V(v5_int) - pow(V(v5_int),3)/5 - V(w5_int) + D_eff * (tanh(3.14159*(0.5 - V(u5_int))) + 0.05) * ((V(v0_int) - V(v5_int)) + (V(v10_int) - V(v5_int)) + (V(v9_int) - V(v5_int)) + (V(v6_int) - V(v5_int))) - alpha_cog*tanh(V(v5_int))
B_dw5 w5_node 0 V = eps * (V(v5_int) + a - b * V(w5_int))
B_du5 u5_node 0 V = eps_u * (sigma_base - V(u5_int))

* Unit 6: dv/dt
B_dv6 v6_node 0 V = V(v6_int) - pow(V(v6_int),3)/5 - V(w6_int) + D_eff * (tanh(3.14159*(0.5 - V(u6_int))) + 0.05) * ((V(v1_int) - V(v6_int)) + (V(v11_int) - V(v6_int)) + (V(v5_int) - V(v6_int)) + (V(v7_int) - V(v6_int))) - alpha_cog*tanh(V(v6_int))
B_dw6 w6_node 0 V = eps * (V(v6_int) + a - b * V(w6_int))
B_du6 u6_node 0 V = eps_u * (sigma_base - V(u6_int))

* Unit 7: dv/dt
B_dv7 v7_node 0 V = V(v7_int) - pow(V(v7_int),3)/5 - V(w7_int) + D_eff * (tanh(3.14159*(0.5 - V(u7_int))) + 0.05) * ((V(v2_int) - V(v7_int)) + (V(v12_int) - V(v7_int)) + (V(v6_int) - V(v7_int)) + (V(v8_int) - V(v7_int))) - alpha_cog*tanh(V(v7_int))
B_dw7 w7_node 0 V = eps * (V(v7_int) + a - b * V(w7_int))
B_du7 u7_node 0 V = eps_u * (sigma_base - V(u7_int))

* Unit 8: dv/dt
B_dv8 v8_node 0 V = V(v8_int) - pow(V(v8_int),3)/5 - V(w8_int) + D_eff * (tanh(3.14159*(0.5 - V(u8_int))) + 0.05) * ((V(v3_int) - V(v8_int)) + (V(v13_int) - V(v8_int)) + (V(v7_int) - V(v8_int)) + (V(v9_int) - V(v8_int))) - alpha_cog*tanh(V(v8_int))
B_dw8 w8_node 0 V = eps * (V(v8_int) + a - b * V(w8_int))
B_du8 u8_node 0 V = eps_u * (sigma_base - V(u8_int))

* Unit 9: dv/dt
B_dv9 v9_node 0 V = V(v9_int) - pow(V(v9_int),3)/5 - V(w9_int) + D_eff * (tanh(3.14159*(0.5 - V(u9_int))) + 0.05) * ((V(v4_int) - V(v9_int)) + (V(v14_int) - V(v9_int)) + (V(v8_int) - V(v9_int)) + (V(v5_int) - V(v9_int))) - alpha_cog*tanh(V(v9_int))
B_dw9 w9_node 0 V = eps * (V(v9_int) + a - b * V(w9_int))
B_du9 u9_node 0 V = eps_u * (sigma_base - V(u9_int))

* Unit 10: dv/dt
B_dv10 v10_node 0 V = V(v10_int) - pow(V(v10_int),3)/5 - V(w10_int) + D_eff * (tanh(3.14159*(0.5 - V(u10_int))) + 0.05) * ((V(v5_int) - V(v10_int)) + (V(v15_int) - V(v10_int)) + (V(v14_int) - V(v10_int)) + (V(v11_int) - V(v10_int))) - alpha_cog*tanh(V(v10_int))
B_dw10 w10_node 0 V = eps * (V(v10_int) + a - b * V(w10_int))
B_du10 u10_node 0 V = eps_u * (sigma_base - V(u10_int))

* Unit 11: dv/dt
B_dv11 v11_node 0 V = V(v11_int) - pow(V(v11_int),3)/5 - V(w11_int) + D_eff * (tanh(3.14159*(0.5 - V(u11_int))) + 0.05) * ((V(v6_int) - V(v11_int)) + (V(v16_int) - V(v11_int)) + (V(v10_int) - V(v11_int)) + (V(v12_int) - V(v11_int))) - alpha_cog*tanh(V(v11_int))
B_dw11 w11_node 0 V = eps * (V(v11_int) + a - b * V(w11_int))
B_du11 u11_node 0 V = eps_u * (sigma_base - V(u11_int))

* Unit 12: dv/dt
B_dv12 v12_node 0 V = V(v12_int) - pow(V(v12_int),3)/5 - V(w12_int) + D_eff * (tanh(3.14159*(0.5 - V(u12_int))) + 0.05) * ((V(v7_int) - V(v12_int)) + (V(v17_int) - V(v12_int)) + (V(v11_int) - V(v12_int)) + (V(v13_int) - V(v12_int))) - alpha_cog*tanh(V(v12_int))
B_dw12 w12_node 0 V = eps * (V(v12_int) + a - b * V(w12_int))
B_du12 u12_node 0 V = eps_u * (sigma_base - V(u12_int))

* Unit 13: dv/dt
B_dv13 v13_node 0 V = V(v13_int) - pow(V(v13_int),3)/5 - V(w13_int) + D_eff * (tanh(3.14159*(0.5 - V(u13_int))) + 0.05) * ((V(v8_int) - V(v13_int)) + (V(v18_int) - V(v13_int)) + (V(v12_int) - V(v13_int)) + (V(v14_int) - V(v13_int))) - alpha_cog*tanh(V(v13_int))
B_dw13 w13_node 0 V = eps * (V(v13_int) + a - b * V(w13_int))
B_du13 u13_node 0 V = eps_u * (sigma_base - V(u13_int))

* Unit 14: dv/dt
B_dv14 v14_node 0 V = V(v14_int) - pow(V(v14_int),3)/5 - V(w14_int) + D_eff * (tanh(3.14159*(0.5 - V(u14_int))) + 0.05) * ((V(v9_int) - V(v14_int)) + (V(v19_int) - V(v14_int)) + (V(v13_int) - V(v14_int)) + (V(v10_int) - V(v14_int))) - alpha_cog*tanh(V(v14_int))
B_dw14 w14_node 0 V = eps * (V(v14_int) + a - b * V(w14_int))
B_du14 u14_node 0 V = eps_u * (sigma_base - V(u14_int))

* Unit 15: dv/dt
B_dv15 v15_node 0 V = V(v15_int) - pow(V(v15_int),3)/5 - V(w15_int) + D_eff * (tanh(3.14159*(0.5 - V(u15_int))) + 0.05) * ((V(v10_int) - V(v15_int)) + (V(v20_int) - V(v15_int)) + (V(v19_int) - V(v15_int)) + (V(v16_int) - V(v15_int))) - alpha_cog*tanh(V(v15_int))
B_dw15 w15_node 0 V = eps * (V(v15_int) + a - b * V(w15_int))
B_du15 u15_node 0 V = eps_u * (sigma_base - V(u15_int))

* Unit 16: dv/dt
B_dv16 v16_node 0 V = V(v16_int) - pow(V(v16_int),3)/5 - V(w16_int) + D_eff * (tanh(3.14159*(0.5 - V(u16_int))) + 0.05) * ((V(v11_int) - V(v16_int)) + (V(v21_int) - V(v16_int)) + (V(v15_int) - V(v16_int)) + (V(v17_int) - V(v16_int))) - alpha_cog*tanh(V(v16_int))
B_dw16 w16_node 0 V = eps * (V(v16_int) + a - b * V(w16_int))
B_du16 u16_node 0 V = eps_u * (sigma_base - V(u16_int))

* Unit 17: dv/dt
B_dv17 v17_node 0 V = V(v17_int) - pow(V(v17_int),3)/5 - V(w17_int) + D_eff * (tanh(3.14159*(0.5 - V(u17_int))) + 0.05) * ((V(v12_int) - V(v17_int)) + (V(v22_int) - V(v17_int)) + (V(v16_int) - V(v17_int)) + (V(v18_int) - V(v17_int))) - alpha_cog*tanh(V(v17_int))
B_dw17 w17_node 0 V = eps * (V(v17_int) + a - b * V(w17_int))
B_du17 u17_node 0 V = eps_u * (sigma_base - V(u17_int))

* Unit 18: dv/dt
B_dv18 v18_node 0 V = V(v18_int) - pow(V(v18_int),3)/5 - V(w18_int) + D_eff * (tanh(3.14159*(0.5 - V(u18_int))) + 0.05) * ((V(v13_int) - V(v18_int)) + (V(v23_int) - V(v18_int)) + (V(v17_int) - V(v18_int)) + (V(v19_int) - V(v18_int))) - alpha_cog*tanh(V(v18_int))
B_dw18 w18_node 0 V = eps * (V(v18_int) + a - b * V(w18_int))
B_du18 u18_node 0 V = eps_u * (sigma_base - V(u18_int))

* Unit 19: dv/dt
B_dv19 v19_node 0 V = V(v19_int) - pow(V(v19_int),3)/5 - V(w19_int) + D_eff * (tanh(3.14159*(0.5 - V(u19_int))) + 0.05) * ((V(v14_int) - V(v19_int)) + (V(v24_int) - V(v19_int)) + (V(v18_int) - V(v19_int)) + (V(v15_int) - V(v19_int))) - alpha_cog*tanh(V(v19_int))
B_dw19 w19_node 0 V = eps * (V(v19_int) + a - b * V(w19_int))
B_du19 u19_node 0 V = eps_u * (sigma_base - V(u19_int))

* Unit 20: dv/dt
B_dv20 v20_node 0 V = V(v20_int) - pow(V(v20_int),3)/5 - V(w20_int) + D_eff * (tanh(3.14159*(0.5 - V(u20_int))) + 0.05) * ((V(v15_int) - V(v20_int)) + (V(v0_int) - V(v20_int)) + (V(v24_int) - V(v20_int)) + (V(v21_int) - V(v20_int))) - alpha_cog*tanh(V(v20_int))
B_dw20 w20_node 0 V = eps * (V(v20_int) + a - b * V(w20_int))
B_du20 u20_node 0 V = eps_u * (sigma_base - V(u20_int))

* Unit 21: dv/dt
B_dv21 v21_node 0 V = V(v21_int) - pow(V(v21_int),3)/5 - V(w21_int) + D_eff * (tanh(3.14159*(0.5 - V(u21_int))) + 0.05) * ((V(v16_int) - V(v21_int)) + (V(v1_int) - V(v21_int)) + (V(v20_int) - V(v21_int)) + (V(v22_int) - V(v21_int))) - alpha_cog*tanh(V(v21_int))
B_dw21 w21_node 0 V = eps * (V(v21_int) + a - b * V(w21_int))
B_du21 u21_node 0 V = eps_u * (sigma_base - V(u21_int))

* Unit 22: dv/dt
B_dv22 v22_node 0 V = V(v22_int) - pow(V(v22_int),3)/5 - V(w22_int) + D_eff * (tanh(3.14159*(0.5 - V(u22_int))) + 0.05) * ((V(v17_int) - V(v22_int)) + (V(v2_int) - V(v22_int)) + (V(v21_int) - V(v22_int)) + (V(v23_int) - V(v22_int))) - alpha_cog*tanh(V(v22_int))
B_dw22 w22_node 0 V = eps * (V(v22_int) + a - b * V(w22_int))
B_du22 u22_node 0 V = eps_u * (sigma_base - V(u22_int))

* Unit 23: dv/dt
B_dv23 v23_node 0 V = V(v23_int) - pow(V(v23_int),3)/5 - V(w23_int) + D_eff * (tanh(3.14159*(0.5 - V(u23_int))) + 0.05) * ((V(v18_int) - V(v23_int)) + (V(v3_int) - V(v23_int)) + (V(v22_int) - V(v23_int)) + (V(v24_int) - V(v23_int))) - alpha_cog*tanh(V(v23_int))
B_dw23 w23_node 0 V = eps * (V(v23_int) + a - b * V(w23_int))
B_du23 u23_node 0 V = eps_u * (sigma_base - V(u23_int))

* Unit 24: dv/dt
B_dv24 v24_node 0 V = V(v24_int) - pow(V(v24_int),3)/5 - V(w24_int) + D_eff * (tanh(3.14159*(0.5 - V(u24_int))) + 0.05) * ((V(v19_int) - V(v24_int)) + (V(v4_int) - V(v24_int)) + (V(v23_int) - V(v24_int)) + (V(v20_int) - V(v24_int))) - alpha_cog*tanh(V(v24_int))
B_dw24 w24_node 0 V = eps * (V(v24_int) + a - b * V(w24_int))
B_du24 u24_node 0 V = eps_u * (sigma_base - V(u24_int))

* ── Simulation ──
.tran 0.1 50 uic

* ── Analysis ──
.control
run
echo "========================================"
echo "  Mem4ristor v3 - 5x5 Network"
echo "========================================"

let v0_final = v(v0_int)[length(v(v0_int))-1]
let v_half = v(v12_int)[length(v(v12_int))-1]

echo "Final states (sample):"
echo "  v[0] = $&v0_final"
echo "  v[12] = $&v_half"
quit
.endc

.end
